//
//
//*** This file is auto generated by IDesignSpec (http://www.agnisys.com) . Please do not edit this file. ***
// created on        : 2023-04-27T10:06:51.126+01:00
// created by        : 
// generated by      : zbqtcf
// generated from    : /sim/tmp/zbqtcf/AR0820_rev2p1/asic/logic/data_path/dv/dp_delay_buffers/regmodel/agnisys_sandbox/csv_to_rdl/dp_delay_buffers_ship_ral_ids.csv
// IDesignSpec rev   : idsbatch v 7.62.0.0 

//*** This code is generated with following settings ***
// Reg Width                  : 32
// Address Unit               : 8
// C++ Types int              : hwint
// Bus Type                   : I2C
// BigEndian                  : true
// LittleEndian               : true
// Dist. Decode and Readback  : false
//--------------------------------------------------------------------------------------------------------------- 
     `ifndef IDS_UDP
              
     `endif
property page_select { type = string; component=reg;};
property page_count { type = number; component=reg;};
property cheader_filler {type = boolean; component = addrmap;};
addrmap dp_delay_buffers {
  cheader_filler = false;
  name  = "dp_delay_buffers Address Map";
  signal {signalwidth=1;} context_b_ship;
  reg select {
    //field {
    //}nfload = 0;
    field {
    }context_b_sel = 0;
  };
  reg y_addr_start_ { 
     regwidth = 16;
     page_count = 2;
     page_select = "select.context_b_sel";
    field {
      hw = rw;
      sw = rw;
      
    } y_addr_start_[11:0] = 12'h0;

  };
 
  reg x_addr_start_ { 
     regwidth = 16;
    field {
      hw = rw;
      sw = rw;
      
    } x_addr_start_[12:0] = 13'h0;

  };
 
  reg y_addr_end_ { 
     regwidth = 16;
    field {
      hw = rw;
      sw = rw;
      
    } y_addr_end_[11:0] = 12'h877;

  };
 
  reg x_addr_end_ { 
     regwidth = 16;
    field {
      hw = rw;
      sw = rw;
      
    } x_addr_end_[12:0] = 13'h0F07;

  };
 
  reg line_length_pck_ { 
     regwidth = 16;
    field {
      hw = rw;
      sw = rw;
      
    } line_length_pck_[15:0] = 16'h0434;

  };
 
  reg lock_control { 
     regwidth = 16;
    field {
      hw = rw;
      sw = rw;
      
    } lock_control[15:0] = 16'hBEEF;

  };
 
  reg reset_register { 
     regwidth = 16;
    field {
      hw = rw;
      sw = rw;
      
    } stb_frame_end[0:0] = 1'h1;

  };
 
  reg line_length_pck_cb { 
     regwidth = 16;
    field {
      hw = rw;
      sw = rw;
      
    } line_length_pck_cb[15:0] = 16'h0;

  };
 
  reg read_mode { 
     regwidth = 16;
    field {
      hw = rw;
      sw = rw;
      
    } stats_rows_nr[1:0] = 2'h0;
    field {
      hw = rw;
      sw = rw;
      
    } embed_rows_nr[3:2] = 2'h0;
    field {
      hw = rw;
      sw = rw;
      
    } col_sum[5:5] = 1'h0;
    field {
      hw = rw;
      sw = rw;
      
    } row_bin_cb[10:10] = 1'h0;
    field {
      hw = rw;
      sw = rw;
      
    } col_bin_cb[11:11] = 1'h0;
    field {
      hw = rw;
      sw = rw;
      
    } row_bin[12:12] = 1'h0;
    field {
      hw = rw;
      sw = rw;
      
    } col_bin[13:13] = 1'h0;
    field {
      hw = rw;
      sw = rw;
      
    } mirror_col[14:14] = 1'h0;

  };
 
  reg dark_control { 
     regwidth = 16;
    field {
      hw = rw;
      sw = rw;
      
    } show_overscan[1:1] = 1'h0;
    field {
      hw = rw;
      sw = rw;
      
    } gen_rrc_flag[6:6] = 1'h0;
    field {
      hw = rw;
      sw = rw;
      
    } show_dark_cols[8:8] = 1'h0;
    field {
      hw = rw;
      sw = rw;
      
    } show_dark_extra_rows[11:11] = 1'h0;
    field {
      hw = rw;
      sw = rw;
      
    } show_atr[12:12] = 1'h0;
    field {
      hw = rw;
      sw = rw;
      
    } show_dtr[13:13] = 1'h0;

  };
 
  reg smia_test { 
     regwidth = 16;
    field {
      hw = rw;
      sw = rw;
      
    } embedded_stats_en[7:7] = 1'h0;
    field {
      hw = rw;
      sw = rw;
      
    } embedded_data_en[8:8] = 1'h1;

  };
 
  reg datapath_select { 
     regwidth = 16;
    field {
      hw = rw;
      sw = rw;
      
    } ime_mode[2:2] = 1'h0;

  };
 
  reg test_pattern_mode_ { 
     regwidth = 16;
    field {
      hw = rw;
      sw = rw;
      
    } test_pattern[2:0] = 3'h0;
    field {
      hw = rw;
      sw = rw;
      
    } walking_1_mode[8:8] = 1'h0;

  };
 
  reg test_raw_mode { 
     regwidth = 16;
    field {
      hw = rw;
      sw = rw;
      
    } raw_data[0:0] = 1'h0;
    field {
      hw = rw;
      sw = rw;
      
    } test_pattern_override[1:1] = 1'h0;

  };
 
  reg config_tsel { 
     regwidth = 16;
    field {
      hw = rw;
      sw = rw;
      
    } tsel[1:0] = 2'h0;

  };
 
  reg operation_mode_ctrl_ { 
     regwidth = 16;
    field {
      hw = rw;
      sw = rw;
      
    } num_exp[3:2] = 2'h1;
    field {
      hw = rw;
      sw = rw;
      
    } line_interleave_mode[4:4] = 1'h0;
    field {
      hw = rw;
      sw = rw;
      
    } line_interleave_combo_mode[5:5] = 1'h0;
    field {
      hw = rw;
      sw = rw;
      
    } monochrome[7:7] = 1'h0;

  };
 
  reg operation_mode_ctrl_cb { 
     regwidth = 16;
    field {
      hw = rw;
      sw = rw;
      
    } num_exp_CB[3:2] = 2'h1;
    field {
      hw = rw;
      sw = rw;
      
    } line_interleave_mode_CB[4:4] = 1'h0;
    field {
      hw = rw;
      sw = rw;
      
    } line_interleave_combo_mode_CB[5:5] = 1'h0;
    field {
      hw = rw;
      sw = rw;
      
    } monochrome_CB[7:7] = 1'h0;

  };
 
  reg x_addr_start_cb { 
     regwidth = 16;
    field {
      hw = rw;
      sw = rw;
      
    } x_addr_start_cb[12:0] = 13'h0;

  };
 
  reg y_addr_start_cb { 
     regwidth = 16;
    field {
      hw = rw;
      sw = rw;
      
    } y_addr_start_cb[11:0] = 12'h0;

  };
 
  reg x_addr_end_cb { 
     regwidth = 16;
    field {
      hw = rw;
      sw = rw;
      
    } x_addr_end_cb[12:0] = 13'h0F07;

  };
 
  reg y_addr_end_cb { 
     regwidth = 16;
    field {
      hw = rw;
      sw = rw;
      
    } y_addr_end_cb[11:0] = 12'h877;

  };
 
  reg x_odd_inc_ { 
     regwidth = 16;
    field {
      hw = rw;
      sw = rw;
      
    } x_odd_inc_[2:0] = 3'h1;

  };
 
  reg x_odd_inc_cb { 
     regwidth = 16;
    field {
      hw = rw;
      sw = rw;
      
    } x_odd_inc_cb[2:0] = 3'h1;

  };
 
  reg digital_test { 
     regwidth = 16;
    field {
      hw = rw;
      sw = rw;
      
    } context_b[13:13] = 1'h0;

  };
 
  reg digital_ctrl { 
     regwidth = 16;
    field {
      hw = rw;
      sw = rw;
      
    } num_exp_max[1:0] = 2'h1;
    field {
      hw = rw;
      sw = rw;
      
    } roi8_min_max_en[2:2] = 1'h0;
    field {
      hw = rw;
      sw = rw;
      
    } read_all_cols[3:3] = 1'h0;
    field {
      hw = rw;
      sw = rw;
      
    } decomp_dither_en[4:4] = 1'h0;

  };
 
  reg noise_pedestal { 
     regwidth = 16;
    field {
      hw = rw;
      sw = rw;
      
    } noise_pedestal_level[11:0] = 12'h040;

  };
 
  reg delta_dk_control { 
     regwidth = 16;
    field {
      hw = rw;
      sw = rw;
      
    } delta_dk_top_rows_nr[3:0] = 4'h2;

  };
 
  reg read_mode2 { 
     regwidth = 16;
    field {
      hw = rw;
      sw = rw;
      
    } readout[5:0] = 6'h0;
    field {
      hw = rw;
      sw = rw;
      
    } readout_cb[13:8] = 6'h09;

  };
 
  reg test_asil_rows { 
     regwidth = 16;
    field {
      hw = rw;
      sw = rw;
      
    } digital_test_btm_rows_nr[3:0] = 4'h0;
    field {
      hw = rw;
      sw = rw;
      
    } digital_test_top_rows_nr[7:4] = 4'h1;
    field {
      hw = rw;
      sw = rw;
      
    } analog_test_btm_rows_nr[11:8] = 4'h1;
    field {
      hw = rw;
      sw = rw;
      
    } analog_test_top_rows_nr[15:12] = 4'h0;

  };
 
  reg vert_shading_control { 
     regwidth = 16;
    field {
      hw = rw;
      sw = rw;
      
    } delta_dark_btm_rows_nr[7:4] = 4'h0;

  };
 
  reg test_ctrl { 
     regwidth = 16;
    field {
      hw = rw;
      sw = rw;
      
    } tar_addr_mode[0:0] = 1'h0;

  };
 
  reg dummy_pixel_value { 
     regwidth = 16;
    field {
      hw = rw;
      sw = rw;
      
    } padding_data[11:0] = 12'h04;

  };
 
  reg configure_buffers1 { 
     regwidth = 16;
    field {
      hw = rw;
      sw = rw;
      
    } configure_buffers_t1[7:0] = 8'h84;
    field {
      hw = rw;
      sw = rw;
      
    } configure_buffers_t2[15:8] = 8'h14;

  };
 
  reg configure_buffers2 { 
     regwidth = 16;
    field {
      hw = rw;
      sw = rw;
      
    } configure_buffers_t3[7:0] = 8'h0C;
    field {
      hw = rw;
      sw = rw;
      
    } configure_buffers_en[8:8] = 1'h0;
    field {
      hw = rw;
      sw = rw;
      
    } db_mem_pack[11:11] = 1'h0;
    field {
      hw = rw;
      sw = rw;
      
    } db_nocompress[12:12] = 1'h0;
    field {
      hw = rw;
      sw = rw;
      
    } db_min_exp[13:13] = 1'h0;
    field {
      hw = rw;
      sw = rw;
      
    } db_expand_knee_point[14:14] = 1'h0;
    field {
      hw = rw;
      sw = rw;
      
    } db_decompand_to_middle[15:15] = 1'h0;

  };
 
  reg delay_buffer_crc_fault_control { 
     regwidth = 16;
    field {
      hw = rw;
      sw = rw;
      
    } delay_buffer_crc_fault_reset[0:0] = 1'h0;
    field {
      hw = rw;
      sw = rw;
      
    } delay_buffer_crc_fault_en[1:1] = 1'h0;
    field {
      hw = rw;
      sw = rw;
      
    } delay_buffer_sys_check_en[2:2] = 1'h0;
    field {
      hw = rw;
      sw = rw;
      
    } delay_buffer_fault_ins[4:4] = 1'h0;
    field {
      hw = rw;
      sw = rw;
      
    } delay_buffer_fault_pixel[15:5] = 11'h0;

  };
 
  reg configure_buffers1_cb { 
     regwidth = 16;
    field {
      hw = rw;
      sw = rw;
      
    } configure_buffers_t1_cb[7:0] = 8'h84;
    field {
      hw = rw;
      sw = rw;
      
    } configure_buffers_t2_cb[15:8] = 8'h18;

  };
 
  reg configure_buffers2_cb { 
     regwidth = 16;
    field {
      hw = rw;
      sw = rw;
      
    } configure_buffers_t3_cb[7:0] = 8'h0C;
    field {
      hw = rw;
      sw = rw;
      
    } configure_buffers_en_cb[8:8] = 1'h0;
    field {
      hw = rw;
      sw = rw;
      
    } db_mem_pack_cb[11:11] = 1'h0;

  };
 
  reg tilt_ctrl { 
     regwidth = 16;
    field {
      hw = rw;
      sw = rw;
      
    } tilt_rows_nr[2:0] = 3'h0;
    field {
      hw = rw;
      sw = rw;
      
    } use_tilt_as_delta_dk[15:15] = 1'h0;

  };
 
  reg roi1_y_addr_start { 
     regwidth = 16;
    field {
      hw = rw;
      sw = rw;
      
    } roi1_y_addr_start[11:0] = 12'h0;

  };
 
  reg roi1_y_addr_end { 
     regwidth = 16;
    field {
      hw = rw;
      sw = rw;
      
    } roi1_y_addr_end[11:0] = 12'h0;

  };
 
  reg roi2_x_addr_start { 
     regwidth = 16;
    field {
      hw = rw;
      sw = rw;
      
    } roi2_x_addr_start[12:0] = 13'h0;

  };
 
  reg roi2_x_addr_end { 
     regwidth = 16;
    field {
      hw = rw;
      sw = rw;
      
    } roi2_x_addr_end[12:0] = 13'h0;

  };
 
  reg roi2_y_addr_start { 
     regwidth = 16;
    field {
      hw = rw;
      sw = rw;
      
    } roi2_y_addr_start[11:0] = 12'h0;

  };
 
  reg roi2_y_addr_end { 
     regwidth = 16;
    field {
      hw = rw;
      sw = rw;
      
    } roi2_y_addr_end[11:0] = 12'h0;

  };
 
  reg roi3_x_addr_start { 
     regwidth = 16;
    field {
      hw = rw;
      sw = rw;
      
    } roi3_x_addr_start[12:0] = 13'h0;

  };
 
  reg roi3_x_addr_end { 
     regwidth = 16;
    field {
      hw = rw;
      sw = rw;
      
    } roi3_x_addr_end[12:0] = 13'h0;

  };
 
  reg roi3_y_addr_start { 
     regwidth = 16;
    field {
      hw = rw;
      sw = rw;
      
    } roi3_y_addr_start[11:0] = 12'h0;

  };
 
  reg roi3_y_addr_end { 
     regwidth = 16;
    field {
      hw = rw;
      sw = rw;
      
    } roi3_y_addr_end[11:0] = 12'h0;

  };
 
  reg roi4_x_addr_start { 
     regwidth = 16;
    field {
      hw = rw;
      sw = rw;
      
    } roi4_x_addr_start[12:0] = 13'h0;

  };
 
  reg roi4_x_addr_end { 
     regwidth = 16;
    field {
      hw = rw;
      sw = rw;
      
    } roi4_x_addr_end[12:0] = 13'h0;

  };
 
  reg roi4_y_addr_start { 
     regwidth = 16;
    field {
      hw = rw;
      sw = rw;
      
    } roi4_y_addr_start[11:0] = 12'h0;

  };
 
  reg roi4_y_addr_end { 
     regwidth = 16;
    field {
      hw = rw;
      sw = rw;
      
    } roi4_y_addr_end[11:0] = 12'h0;

  };
 
  reg roi5_x_addr_start { 
     regwidth = 16;
    field {
      hw = rw;
      sw = rw;
      
    } roi5_x_addr_start[12:0] = 13'h0;

  };
 
  reg roi5_x_addr_end { 
     regwidth = 16;
    field {
      hw = rw;
      sw = rw;
      
    } roi5_x_addr_end[12:0] = 13'h0;

  };
 
  reg roi5_y_addr_start { 
     regwidth = 16;
    field {
      hw = rw;
      sw = rw;
      
    } roi5_y_addr_start[11:0] = 12'h0;

  };
 
  reg roi5_y_addr_end { 
     regwidth = 16;
    field {
      hw = rw;
      sw = rw;
      
    } roi5_y_addr_end[11:0] = 12'h0;

  };
 
  reg roi6_x_addr_start { 
     regwidth = 16;
    field {
      hw = rw;
      sw = rw;
      
    } roi6_x_addr_start[12:0] = 13'h0;

  };
 
  reg roi6_x_addr_end { 
     regwidth = 16;
    field {
      hw = rw;
      sw = rw;
      
    } roi6_x_addr_end[12:0] = 13'h0;

  };
 
  reg roi6_y_addr_start { 
     regwidth = 16;
    field {
      hw = rw;
      sw = rw;
      
    } roi6_y_addr_start[11:0] = 12'h0;

  };
 
  reg roi6_y_addr_end { 
     regwidth = 16;
    field {
      hw = rw;
      sw = rw;
      
    } roi6_y_addr_end[11:0] = 12'h0;

  };
 
  reg roi7_x_addr_start { 
     regwidth = 16;
    field {
      hw = rw;
      sw = rw;
      
    } roi7_x_addr_start[12:0] = 13'h0;

  };
 
  reg roi7_x_addr_end { 
     regwidth = 16;
    field {
      hw = rw;
      sw = rw;
      
    } roi7_x_addr_end[12:0] = 13'h0;

  };
 
  reg roi7_y_addr_start { 
     regwidth = 16;
    field {
      hw = rw;
      sw = rw;
      
    } roi7_y_addr_start[11:0] = 12'h0;

  };
 
  reg roi7_y_addr_end { 
     regwidth = 16;
    field {
      hw = rw;
      sw = rw;
      
    } roi7_y_addr_end[11:0] = 12'h0;

  };
 
  reg roi0_x_addr_start { 
     regwidth = 16;
    field {
      hw = rw;
      sw = rw;
      
    } roi0_x_addr_start[12:0] = 13'h0;

  };
 
  reg roi0_x_addr_end { 
     regwidth = 16;
    field {
      hw = rw;
      sw = rw;
      
    } roi0_x_addr_end[12:0] = 13'h0;

  };
 
  reg roi0_y_addr_start { 
     regwidth = 16;
    field {
      hw = rw;
      sw = rw;
      
    } roi0_y_addr_start[11:0] = 12'h0;

  };
 
  reg roi0_y_addr_end { 
     regwidth = 16;
    field {
      hw = rw;
      sw = rw;
      
    } roi0_y_addr_end[11:0] = 12'h0;

  };
 
  reg roi1_x_addr_start { 
     regwidth = 16;
    field {
      hw = rw;
      sw = rw;
      
    } roi1_x_addr_start[12:0] = 13'h0;

  };
 
  reg roi1_x_addr_end { 
     regwidth = 16;
    field {
      hw = rw;
      sw = rw;
      
    } roi1_x_addr_end[12:0] = 13'h0;

  };


  select select; 
 
  y_addr_start_ y_addr_start_ @0x3002;

  x_addr_start_ x_addr_start_ @0x3004;

  y_addr_end_ y_addr_end_ @0x3006;

  x_addr_end_ x_addr_end_ @0x3008;

  line_length_pck_ line_length_pck_ @0x300C;

  lock_control lock_control @0x3010;

  reset_register reset_register @0x301A;

  line_length_pck_cb line_length_pck_cb @0x303E;

  read_mode read_mode @0x3040;

  dark_control dark_control @0x3044;

  smia_test smia_test @0x3064;

  datapath_select datapath_select @0x306E;

  test_pattern_mode_ test_pattern_mode_ @0x3070;

  test_raw_mode test_raw_mode @0x307A;

  config_tsel config_tsel @0x307C;

  operation_mode_ctrl_ operation_mode_ctrl_ @0x3082;

  operation_mode_ctrl_cb operation_mode_ctrl_cb @0x3084;

  x_addr_start_cb x_addr_start_cb @0x308A;

  y_addr_start_cb y_addr_start_cb @0x308C;

  x_addr_end_cb x_addr_end_cb @0x308E;

  y_addr_end_cb y_addr_end_cb @0x3090;

  x_odd_inc_ x_odd_inc_ @0x30A2;

  x_odd_inc_cb x_odd_inc_cb @0x30AE;

  digital_test digital_test @0x30B0;

  digital_ctrl digital_ctrl @0x30BA;

  noise_pedestal noise_pedestal @0x30FE;

  delta_dk_control delta_dk_control @0x3180;

  read_mode2 read_mode2 @0x32FC;

  test_asil_rows test_asil_rows @0x33E0;

  vert_shading_control vert_shading_control @0x33E4;

  test_ctrl test_ctrl @0x33EE;

  dummy_pixel_value dummy_pixel_value @0x33F2;

  configure_buffers1 configure_buffers1 @0x3C06;

  configure_buffers2 configure_buffers2 @0x3C08;

  delay_buffer_crc_fault_control delay_buffer_crc_fault_control @0x3C0A;

  configure_buffers1_cb configure_buffers1_cb @0x3C80;

  configure_buffers2_cb configure_buffers2_cb @0x3C82;

  tilt_ctrl tilt_ctrl @0x3E3E;

  roi1_y_addr_start roi1_y_addr_start @0x5812;

  roi1_y_addr_end roi1_y_addr_end @0x5814;

  roi2_x_addr_start roi2_x_addr_start @0x5816;

  roi2_x_addr_end roi2_x_addr_end @0x5818;

  roi2_y_addr_start roi2_y_addr_start @0x581A;

  roi2_y_addr_end roi2_y_addr_end @0x581C;

  roi3_x_addr_start roi3_x_addr_start @0x581E;

  roi3_x_addr_end roi3_x_addr_end @0x5820;

  roi3_y_addr_start roi3_y_addr_start @0x5822;

  roi3_y_addr_end roi3_y_addr_end @0x5824;

  roi4_x_addr_start roi4_x_addr_start @0x5826;

  roi4_x_addr_end roi4_x_addr_end @0x5828;

  roi4_y_addr_start roi4_y_addr_start @0x582A;

  roi4_y_addr_end roi4_y_addr_end @0x582C;

  roi5_x_addr_start roi5_x_addr_start @0x582E;

  roi5_x_addr_end roi5_x_addr_end @0x5830;

  roi5_y_addr_start roi5_y_addr_start @0x5832;

  roi5_y_addr_end roi5_y_addr_end @0x5834;

  roi6_x_addr_start roi6_x_addr_start @0x5836;

  roi6_x_addr_end roi6_x_addr_end @0x5838;

  roi6_y_addr_start roi6_y_addr_start @0x583A;

  roi6_y_addr_end roi6_y_addr_end @0x583C;

  roi7_x_addr_start roi7_x_addr_start @0x583E;

  roi7_x_addr_end roi7_x_addr_end @0x5840;

  roi7_y_addr_start roi7_y_addr_start @0x5842;

  roi7_y_addr_end roi7_y_addr_end @0x5844;

  roi0_x_addr_start roi0_x_addr_start @0x5876;

  roi0_x_addr_end roi0_x_addr_end @0x5878;

  roi0_y_addr_start roi0_y_addr_start @0x587A;

  roi0_y_addr_end roi0_y_addr_end @0x587C;

  roi1_x_addr_start roi1_x_addr_start @0x587E;

  roi1_x_addr_end roi1_x_addr_end @0x5880;

};
